;=========Config=========
;---------START--------
libTech = strcat( "tsmcN3" )
strmVer = strcat( "6" )

listDMYinst = list(
    list("BEOL_" "" "")
    list("FEOL_" "" "")
) ;; listDMYinst is topcell for dummies
listDMYgds = list(
    list("" "" "_BEOL.gds")
    list("" "" "_FEOL.gds")
) ;; listDMYgds is gds of dummies

;; Example
;; list("" "" "_gf") --> cellName_gf
;; list("" "" ".swap.marker.gds") --> cellName.swap.marker.gds
;; list("BEOL_" "" ".swap.marker.gds") --> BEOL_cellName.swap.marker.gds
;; list("BEOL_" "MAIN" ".swap.marker.gds") --> BEOL_MAIN.swap.marker.gds
;---------END---------

;---------START--------
hiSetBindKeys("Layout" list(list("Ctrl Shift<Key> Z" "rmdmy()")))
hiSetBindKeys("Layout" list(list("Ctrl Shift<Key> X" "gendmy(\"cell\")")))
hiSetBindKeys("Layout" list(list("Ctrl Shift<Key> C" "gendmy(\"fullchip\")")))
hiSetBindKeys("Layout" list(list("Ctrl Shift<Key> V" "flatdmy()")))
;; hiSetBindKeys("Layout" list(list("Ctrl Shift<Key> Q" "rmchilddmy()")))

dmyDir = strcat("/" buildString(reverse(cdr(reverse(parseString(get_filename(piport) "/"))))  "/"))
procedure(rmdmy()
	let((cv DMYcell)
	cv = geGetWindowCellView()
	printf("==================================================================\n")
	printf("STARTING REMOVE TRAIL DUMMY\n")
	printf("LIBRARY NAME: [%s]\n" cv~>libName)
	printf("CELL NAME: [%s]\n" cv~>cellName)
	printf("VIEW NAME: [%s]\n" cv~>viewName)
	printf("==================================================================\n")

    foreach(DMYcell RVC_Dummy_Instance_list(listDMYinst cv~>cellName)
        foreach(instanceDMY cv~>instances
            when(instanceDMY~>cellName==DMYcell
                    dbDeleteObject(instanceDMY)
            )
        )
    )
	printf("==================================================================\n")
	printf("DONE REMOVE TRAIL DUMMY OF [%s]\n" cv~>cellName)
	printf("==================================================================\n")
	)
)

procedure(gendmy(flag)
	let((cv StrmOutFile OutputDummy)
        cv = geGetWindowCellView()
        rmdmy()
        StrmOutFile = strcat(dmyDir  "/input/" cv~>cellName ".gds")
        StrmInDir = strcat(dmyDir  "/output/" cv~>cellName "_" flag)
        DummyLibName = strcat(cv~>libName "_DMY4chk")
        DF4DMY = strcat(dmyDir  "/DF4DMY")

        ; RVC_DeleteLib(DummyLibName)
        RVC_ExtractGDS(StrmOutFile cv~>libName cv~>cellName cv~>viewName libTech)
        RVC_Go_dmy(cv flag)
        RVC_ImportDummy(StrmInDir DummyLibName DF4DMY)
        ;; RVC_PlaceDummy(DummyLibName)
	)
)
procedure(rmchilddmy()
	let((cv )
	cv = geGetWindowCellView()
	printf("==================================================================\n")
	printf("STARTING REMOVE CHILD DUMMY\n")
	printf("LIBRARY NAME: [%s]\n" cv~>libName)
	printf("CELL NAME: [%s]\n" cv~>cellName)
	printf("VIEW NAME: [%s]\n" cv~>viewName)
	printf("==================================================================\n")
	BEOLcell = strcat("BEOL_" cv~>cellName)
	FEOLcell = strcat("FEOL_" cv~>cellName)
	foreach(instanceDMY cv~>instHeaders
		when(instanceDMY~>libName==childlib
		      foreach(instanceDMY cv~>instHeaders
				    when(instanceDMY~>cellName==BEOLcell || instanceDMY~>cellName==FEOLcell
					    foreach(instance instanceDMY~>instances
					        dbDeleteObject(instance)
					  	)
					)
	      		)
		)
	)
	printf("==================================================================\n")
	printf("DONE REMOVE CHILD DUMMY OF [%s]\n" cv~>cellName)
	printf("==================================================================\n")
	)
)
procedure(RVC_Dummy_Instance_list(PrefixPostfix_list cellName)
    prog((PrefixPostfix Prefix Main Postfix Dummy_Instance_list)
        Dummy_Instance_list = list()
        foreach(PrefixPostfix PrefixPostfix_list
            Prefix = nth(0 PrefixPostfix)
            Main = nth(1 PrefixPostfix)
            Postfix = nth(2 PrefixPostfix)
            if(Main == "" then
                Dummy_Instance_list = append1(Dummy_Instance_list strcat(Prefix cellName Postfix))
            else
                Dummy_Instance_list = append1(Dummy_Instance_list strcat(Prefix Main Postfix))
            )
        )
        return(Dummy_Instance_list)
    )
)

procedure(RVC_ExtractGDS(StrmOutFile libName cellName viewName libTech)
    xstSetField("strmFile" StrmOutFile)
    xstSetField("library" libName)
    xstSetField("topCell" cellName)
    xstSetField("view" viewName)
    xstSetField("techLib" libTech)
    xstSetField("logFile" "pipo.log")
    xstSetField("virtualMemory" "true")
    xstSetField("showCompletionMsgBox" "false")
    printf("==================================================================\n")
    printf("STARTING GENERATE GDS \n")
    printf("LIBRARY NAME: [%s]\n" libName)
    printf("CELL NAME: [%s]\n" cellName)
    printf("VIEW NAME: [%s]\n" viewName)
    printf("==================================================================\n")
    xstOutDoTranslate( )
    printf("==================================================================\n")
    printf("DONE GENERATE GDS FOR CELL [%s]\n" cellName)
    printf("==================================================================\n")
    printf("\n")
    printf("\n")
)
procedure(RVC_Go_dmy(cv flag)
    let((cmd path_type path_log cid)
        printf("==================================================================\n")
        printf("STARTING GENERATE DUMMY \n")
        printf("LIBRARY NAME: [%s]\n" cv~>libName)
        printf("CELL NAME: [%s]\n" cv~>cellName)
        printf("VIEW NAME: [%s]\n" cv~>viewName)
        printf("==================================================================\n")
        cmd = strcat("cd " dmyDir "; csh go_dmy.csh "  cv~>cellName " " flag)
        printf("RUN COMMAND:[%s]\n" cmd)
        path_type = strcat(cv~>cellName "_" flag)
        printf("OUTPUT_PATH:[%s/%s]\n" dmyDir, path_type)
        path_log = strcat(dmyDir "/LOG/" cv~>cellName  "_dmy.log")
        printf("OUTPUT_LOG:[%s]\n" path_log)
        ; csh(cmd)
        cid = ipcBatchProcess(cmd "" path_log)
        ipcWait(cid)
        printf("==================================================================\n")
        printf("DONE GENERATE DUMMY FOR [%s]\n" cv~>cellName)
        printf("==================================================================\n")
   )
)

procedure(RVC_ImportDummy(StrmInDir DummyLibName DF4DMY)
    ;; StrmInDir: GDS dir
    ;; DummyLibName: Name of top cell need to be imported
    ;; DF4DMY: DF2 for dummy lib
	let((StrmInFile)
        printf("==================================================================\n")
        printf("STARTING STREAM IN: [%s]\n" StrmInDir)
        printf("Dummy cells is STREAMING TO lib [%s] \n" DummyLibName)
        printf("[%s] library was put at: [%s]\n" DummyLibName DF4DMY)
        printf("==================================================================\n")
        CCScreateLib(DummyLibName strcat(DF4DMY "/" DummyLibName) libTech)
        foreach(fillfile RVC_Dummy_Instance_list(listDMYgds cv~>cellName)
            StrmInFile = strcat(StrmInDir "/" fillfile)
            xstInSetField("strmFile" StrmInFile)
            xstInSetField("library" DummyLibName)
            xstInSetField("topCell" "")
            xstInSetField("view" "layout")
            xstInSetField("attachTechFileofLib" libTech)
            xstInSetField("virtualMemory" "true")
            xstInSetField("showCompletionMsgBox" "false")
            xstInDoTranslate( )
            procedure( xstInOnCompletion( status )
                printf("In xstInOnCompletion of XStream In GUI: %d\n" status)
                if( status == 0 then
                    printf("Successfully completed\n" status)
                    vmlib = ddGetObj(DummyLibName)
                    foreach((cell) vmlib~>cells~>name
                        CELLid = dbOpenCellViewByType(DummyLibName cell "layout" "maskLayout" "a")
                        dbSave(CELLid)
                        dbPurge(CELLid)
                    )
                else
                    error("Error occured during translation")
                )
                RVC_PlaceDummy(DummyLibName)
            )
        )
	)
)
procedure(RVC_PlaceDummy(DummyLibName)
	let((cv cv1 schinst vmlib)
        cv = geGetWindowCellView()
        printf("==================================================================\n")
        printf("STARTING PLACE DUMMY: [%s]\n" cv~>cellName)
        printf("Dummy cell place from lib [%s] \n" DummyLibName)
        foreach(fillcell RVC_Dummy_Instance_list(listDMYinst cv~>cellName)
            cv1 = dbOpenCellViewByType(DummyLibName fillcell "layout" "maskLayout" "a")
            printf(fillcell)
            printf("Dummy [%s] \n" fillcell)
            schinst=dbCreateInst(cv cv1 nil list(0 0) "R0" 1)
            vmlib = ddGetObj(DummyLibName)
            foreach((cell) vmlib~>cells~>name
                CELLid = dbOpenCellViewByType(DummyLibName cell "layout" "maskLayout" "a")
                dbSave(CELLid)
                dbPurge(CELLid)
            )
        )
        printf("==================================================================\n")
	)
)
procedure(flatdmy()
	let((libDMY viewDMY BEOLcell FEOLcell cellDMY cv)
        cv = geGetWindowCellView()
        libDMY = strcat(cv~>libName "_DMY4chk")
        printf(libDMY)
        printf("\n")
        foreach((cell) RVC_Dummy_Instance_list(listDMYinst cv~>cellName)
            DMYid = dbOpenCellViewByType(libDMY cell "layout")
            cpDMYid = dbCopyCellView(DMYid cv~>libName cell "layout")
            DMYid = dbOpenCellViewByType(cv~>libName cell "layout" "" "a")
            foreach((inst) DMYid~>instances
                leFlattenInst(inst 31)
            )
            dbPurge(DMYid)
            foreach(inst cv~>instances
                if(inst~>cellName == cell then
                    master = dbOpenCellViewByType(cv~>libName cell "layout")
                    inst~>master = master
                )
            )
        )
        printf("==================================================================\n")
        printf("DONE FLATTEN DUMMY CELL: [%s]\n" cv~>cellName)
        printf("==================================================================\n")
        printf("\n")
        printf("\n")
	)
)
procedure(CCScreateLib(libName libLocation techLib)
	let((desLib)
        when(desLib=ddGetObj(libName)
            warn("Library named [%s] already exist at path [%s]" libName desLib~>readPath)
        )
        unless(isDir(libLocation)
            warn("Provided library location [%s] does not exist. It will be generated automatically." libLocation)
            createDirHier( libLocation )
        )
        desLib=ddCreateLib(libName libLocation)
        unless(ddGetObj(techLib)
            error("Unable to attach design library [%]s to techlib because\n
            techlib [%]s not defined in cds.lib and unavailable in library Manager" libName techLib)
        )
        when(desLib
            techBindTechFile(desLib techLib)
        )
	)
)
procedure(RVC_DeleteLib(DummyLibName)
	let((cmd desLib)
        when(desLib=ddGetObj(DummyLibName)
            ddDeleteObj(ddGetObj(DummyLibName))
            cmd = strcat("sed -i '/" DummyLibName "/d' cds.lib" )
            csh(cmd)
        )
	)
)
;---------END--------
